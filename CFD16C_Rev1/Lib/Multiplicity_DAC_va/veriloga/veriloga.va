// VerilogA for Lib, Multiplicity_DAC, veriloga

`include "constants.vams"
`include "disciplines.vams"

`define NUM_CHANNELS 16 //number of channels

module Multiplicity_DAC(IN, AVDD, AVSS, SVSS, OUT);
	input[`NUM_CHANNELS-1:0] IN;
	input AVDD, AVSS, SVSS;
	output OUT;

	electrical[`NUM_CHANNELS-1:0] IN;
	electrical AVDD, AVSS, SVSS, OUT;

	parameter real vref = 1.25; //DAC reference
	parameter real tr = 1n; //rise  time
	parameter real tf = 1n; //fall time
	parameter real tpd = 0; //propogation delay

	real weight; //the weight of the bit beign evaluated
	real dval; //the decimal value of the DAC inputs
	real vth; //logic threshol d
	genvar j; //genvar for unrolled loops

	analog begin
		dval = 0;
		vth = (V(AVDD) + V(AVSS))/2.0; //compute the logic threshold
		weight = 0.5;

		//determine which bus lines are high and change code word accordingly
		for(j = `NUM_CHANNELS-1; j >= 0; j = j-1) begin
			dval = dval + (V(IN[j]) > vth ? weight:0.0);
			weight = weight/2.0;
		end

		//Change analog voltage
		V(OUT) <+ transition(vref*dval, tpd, tr, tf);
	end
endmodule
