// VerilogA for Lib, lvltrans_PadGnd_PSD, veriloga

`include "constants.vams"
`include "disciplines.vams"

/* The GND pad is composed of a PFET connected as a diode.
*  The PFET source, gate, and bulk are connected to VDD1. It's drain is connected to GND1.
*/
module lvltrans_PadGnd_PSD(GND1, VDD1);
	input GND1;
	electrical GND1;
	input VDD1;
	electrical VDD1;

	//The leakage current of the diode.
	parameter real Is = 1p from[1p:1n];
    parameter real Rs = 200 from[1:inf);

	analog begin
		I(GND1, VDD1) <+ Is*(limexp((V(GND1, VDD1) - Rs*I(GND1, VDD1))/$vt) - 1.0);
	end
endmodule
