// VerilogA for jpLib, nor2, veriloga

`include "constants.vams"
`include "disciplines.vams"

module nor2(OUT, AVDD, AVSS, SVSS, INA, INB);
output OUT;
electrical OUT;
inout AVDD;
electrical AVDD;
inout AVSS;
electrical AVSS;
inout SVSS;
electrical SVSS;
input INA;
electrical INA;
input INB;
electrical INB;
parameter real vlogic_high = 5;
parameter real vlogic_low = 0;
parameter real vtrans = 2.5;
parameter real tdel = 100p from [0:inf);
parameter real trise = 1n from (0:inf);
parameter real tfall = 1n from (0:inf);

   real vout_val;
   integer logic1, logic2;

   analog begin

      @ ( initial_step ) begin
         if (vlogic_high < vlogic_low) begin
            $display("Range specification error.  vlogic_high = (%E) less than vlogic_low = (%E).\n", vlogic_high, vlogic_low );
            $finish;
         end
         if (vtrans > vlogic_high || vtrans < vlogic_low) begin
            $display("Inconsistent $threshold specification w/logic family.\n");
         end
      end

      logic1 = V(INA) > vtrans;
      logic2 = V(INB) > vtrans;

      @ (cross(V(INA) - vtrans, 1))  logic1 = 1;
      @ (cross(V(INA) - vtrans, -1)) logic1 = 0;

      @ (cross(V(INB) - vtrans, 1))  logic2 = 1;
      @ (cross(V(INB) - vtrans, -1)) logic2 = 0;

      //
      // define the logic function.
      //
      vout_val = (!(logic1 || logic2)) ? vlogic_high : vlogic_low;

      V(OUT) <+ transition( vout_val, tdel, trise, tfall);
   end

endmodule
