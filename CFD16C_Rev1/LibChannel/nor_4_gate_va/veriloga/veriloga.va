// VerilogA for poLib, nor_4_gate_va, veriloga

`include "constants.vams"
`include "disciplines.vams"

module nor_4_gate_va(A, B, C, D, F, avdd, avss, svss);
//input & output
	input A, B, C, D, avdd, avss, svss;
	output F;

	electrical A, B, C, D, F, avdd, avss, svss;

//parameter
	parameter tr = 10p;
	parameter tf = 10p;
	parameter tpd = 5n;
	parameter time_tol = 100p;
	real F_electric, voh, vol, vth;

//electric & logic
	integer A_logic, B_logic, C_logic, D_logic, F_logic;
//Behavioral description
	analog begin
		voh = V(avdd);
		vol = V(avss);
		vth = (voh + vol) / 2.0;

		@(initial_step or cross(V(A)-vth, 0, time_tol)) begin
			A_logic = V(A) > vth ? 1 : 0;
		end

		@(initial_step or cross(V(B)-vth, 0, time_tol)) begin
			B_logic = V(B) > vth ? 1 : 0;
		end

		@(initial_step or cross(V(C)-vth, 0, time_tol)) begin
			C_logic = V(C) > vth ? 1 : 0;
		end

		@(initial_step or cross(V(D)-vth, 0, time_tol)) begin
			D_logic = V(D) > vth ? 1 : 0;
		end

		F_logic = A_logic || B_logic || C_logic || D_logic;  //logic function

		if(F_logic == 1) F_electric = vol;
		else if(F_logic == 0) F_electric = voh;

//Assign appropriate voltage to output node
		V(F) <+ transition(F_electric, tpd, tr, tf);
	end
endmodule
